addrmap top {
    reg {
        field {sw=rw; hw=r;} EPID[31:0] = 0;
    } EPID;
};
